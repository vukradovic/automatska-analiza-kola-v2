V1 in 0 DC 1
R1 in out 1k
C1 out 0 100u
.end

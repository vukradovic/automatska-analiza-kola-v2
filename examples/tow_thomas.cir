* Tow-Thomas state-variable biquad (from assignment figure)
* IMG: assets/circuit_images/tow_thomas.png
* Node mapping follows image labels: 1..7, output node is 4, ground=0

* Input source
V1 1 0 DC Ug

* Parameter set from task:
* R1 = 3/2 R
* R2 = R3 = R
* R4 = 3/4 R
* R7 = R8 = R
* C1 = C2 = 1/(R*Om)

R4 1 5 3*R/4
R1 5 2 3*R/2
C1 5 2 1/(R*Om)
R3 5 4 R

R7 2 6 R
R8 3 6 R

R2 3 7 R
C2 7 4 1/(R*Om)

R9 4 0 RL

* Ideal op-amps (direct MNA constraints V+ = V-)
* Oname nout nref nplus nminus
OOP1 2 0 0 5
OOP2 3 0 0 6
OOP3 4 0 0 7
.end
